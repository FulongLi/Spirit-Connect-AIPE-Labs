* 48 V to approximately 12 V isolated flyback -- open-loop LTspice draft
* Dr. Fulong Li -- September 2026. Native LTspice execution pending.
* Generic lossy elements, not a selected or validated hardware BOM.
* Np:Ns = 2:1, so Lsec = Lpri/n^2 = 220u/4 = 55u.
.param VIN=48 FS=100k DUTY=0.3333
.param LP=220u LS=55u CVAL=470u RLOAD=4.8
.param CCL=10n RCL=2.2k
Vinput in 0 {VIN}
* DOT CONVENTION: LTspice puts the dot on the FIRST node listed.
* Primary dot at "in", secondary dot at "0" -- opposite phasing, which is
* what makes this a FLYBACK (secondary conducts while the switch is OFF).
* Swap the secondary node order and it becomes a forward converter.
Lpri in sw {LP}
Lsec 0 sec {LS}
K1 Lpri Lsec 0.995
S1 sw 0 gate 0 SWMOD
* RCD clamp: absorbs the leakage-inductance energy that would otherwise
* avalanche the switch. Rcl is sized from P_leak = 0.5*Llk*Ipk^2*fs.
Dclamp sw clamp DMOD
Cclamp clamp in {CCL}
Rclamp clamp in {RCL}
D1 sec out DMOD
Cout out 0 {CVAL}
Rload out 0 {RLOAD}
Vgate gate 0 PULSE(0 5 10u 10n 10n {DUTY/FS} {1/FS})
.model SWMOD SW(Ron=0.05 Roff=100Meg Vt=2.5 Vh=0)
.model DMOD D(Is=1u N=1.1 Rs=0.02 Cjo=100p Tt=0)
* Watch V(sw): the flat-topped part is Vin + n*Vout = 72 V (the reflected
* voltage), and the spike on top of it is leakage ringing into the clamp.
.tran 0 20m 18m 20n
.options plotwinsize=0
.meas tran Vout_avg AVG V(out) FROM 18m TO 20m
.meas tran Vout_pp PP V(out) FROM 19.98m TO 20m
.meas tran Vsw_max MAX V(sw) FROM 18m TO 20m
.meas tran Ipri_pk MAX I(Lpri) FROM 18m TO 20m
.meas tran Isec_pk MAX I(Lsec) FROM 18m TO 20m
.end
