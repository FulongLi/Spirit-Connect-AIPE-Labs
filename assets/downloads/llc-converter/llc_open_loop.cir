* 390 V to approximately 12 V half-bridge LLC -- open-loop LTspice draft
* Dr. Fulong Li -- September 2026. Native LTspice execution pending.
* Generic lossy elements, not a selected or validated hardware BOM.
* Tank: Lr = 80u, Cr = 33n -> fr = 97.95 kHz. Lm = 400u (Ln = 5).
* n = Np:Ns(half) = 16, so Lsec = Lm/n^2 = 400u/256 = 1.5625u.
* An LLC is regulated by FREQUENCY, not duty. Sweep FSW and watch Vout.
.param VIN=390 FSW=98k
.param LR=80u CR=33n LM=400u LS=1.5625u
.param CVAL=1000u RLOAD=0.6
Vinput in 0 {VIN}
S1 in a g1 0 SWMOD
S2 a 0 g2 0 SWMOD
* Series resonant tank. Cr also blocks DC, so no flux walk.
Lr a b {LR}
Cr b p {CR}
* Lpri IS the magnetising inductance: it is part of the tank, which is
* why an LLC transformer is deliberately built with a LOW coupling factor.
Lpri p 0 {LM}
Lsec1 s1 0 {LS}
Lsec2 0 s2 {LS}
K1 Lpri Lsec1 Lsec2 0.9999
D1 s1 out DMOD
D2 s2 out DMOD
Cout out 0 {CVAL}
Rload out 0 {RLOAD}
* Near-50% complementary drive with dead time. The dead time is NOT
* optional: it is the interval in which the magnetising current charges
* and discharges the switch capacitance to achieve ZVS.
Vg1 g1 0 PULSE(0 5 0 10n 10n {0.46/FSW} {1/FSW})
Vg2 g2 0 PULSE(0 5 {0.5/FSW} 10n 10n {0.46/FSW} {1/FSW})
.model SWMOD SW(Ron=0.1 Roff=100Meg Vt=2.5 Vh=0)
.model DMOD D(Is=1u N=1.05 Rs=0.005 Cjo=500p Tt=0)
* EXPERIMENT: set FSW to 98k (at resonance) and Vout should land near
* 12.2 V. Then try 80k -- gain rises above 1. Then try 130k -- gain falls.
* That single sweep is the whole control principle of an LLC.
.tran 0 4m 3.5m 5n
.options plotwinsize=0
.meas tran Vout_avg AVG V(out) FROM 3.5m TO 4m
.meas tran Vout_pp PP V(out) FROM 3.98m TO 4m
.meas tran Ir_pk MAX I(Lr) FROM 3.5m TO 4m
.meas tran Vcr_pk MAX V(b,p) FROM 3.5m TO 4m
.end
