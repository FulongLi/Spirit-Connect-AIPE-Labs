* 12 V to approximately 24 V boost -- open-loop LTspice teaching draft
* Dr. Fulong Li -- September 2026. Native LTspice execution pending.
* Generic lossy elements, not a selected or validated hardware BOM.
.param VIN=12 FS=100k DUTY=0.5 LVAL=150u CVAL=330u RLOAD=19.2
Vinput in 0 {VIN}
Rwind in lin 0.08
L1 lin sw {LVAL}
S1 sw 0 gate 0 SWMOD
D1 sw out DMOD
Cout out 0 {CVAL}
Rload out 0 {RLOAD}
Vgate gate 0 PULSE(0 5 10u 10n 10n {DUTY/FS} {1/FS})
.model SWMOD SW(Ron=0.02 Roff=100Meg Vt=2.5 Vh=0)
.model DMOD D(Is=1u N=1.1 Rs=0.03 Cjo=100p Tt=0)
* Normal operating-point solution precharges Cout through the input path.
* This is PWM enable, not cold plug-in into an initially discharged board.
.tran 0 100m 90m 100n
.options plotwinsize=0
.meas tran Vout_avg AVG V(out) FROM 90m TO 100m
.meas tran Vout_pp PP V(out) FROM 99m TO 100m
.meas tran IL_avg AVG I(L1) FROM 90m TO 100m
.meas tran IL_peak MAX I(L1) FROM 90m TO 100m
.end
