* 12 V to approximately -12 V Cuk -- open-loop LTspice teaching draft
* Dr. Fulong Li -- September 2026. Native LTspice execution pending.
* Generic lossy elements, not a selected or validated hardware BOM.
* Inverting, with CONTINUOUS current at both the input and the output.
* Note Cout is only 100u yet the output ripple is far smaller than the
* SEPIC's 330u, because L2 feeds the output continuously (buck-like).
.param VIN=12 FS=100k DUTY=0.5 L1VAL=150u L2VAL=150u
.param CSVAL=22u CVAL=100u RLOAD=4.8
Vinput in 0 {VIN}
Rw1 in a1 0.05
L1 a1 a {L1VAL}
S1 a 0 gate 0 SWMOD
* Coupling capacitor sits at Vin + |Vout| (about 24 V here) -- the highest
* stressed passive component in the converter.
Cs a b {CSVAL}
* Freewheel diode: anode at ground, cathode at node b.
D1 0 b DMOD
Rw2 b b2 0.05
L2 b2 out {L2VAL}
Cout out 0 {CVAL}
Rload out 0 {RLOAD}
Vgate gate 0 PULSE(0 5 10u 10n 10n {DUTY/FS} {1/FS})
.model SWMOD SW(Ron=0.02 Roff=100Meg Vt=2.5 Vh=0)
.model DMOD D(Is=1u N=1.1 Rs=0.03 Cjo=100p Tt=0)
* Fourth-order and lightly damped: allow a long settle before measuring.
.tran 0 40m 35m 100n
.options plotwinsize=0
.meas tran Vout_avg AVG V(out) FROM 35m TO 40m
.meas tran Vout_pp PP V(out) FROM 39.98m TO 40m
.meas tran Vcs_avg AVG V(a,b) FROM 35m TO 40m
.meas tran IL1_avg AVG I(L1) FROM 35m TO 40m
.meas tran IL2_avg AVG I(L2) FROM 35m TO 40m
.end
